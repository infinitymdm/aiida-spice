.title sky130_buf_1_in_cap_ac_sweep
.include /home/marcus/.ciel/sky130A/libs.ref/sky130_fd_sc_hd/spice/sky130_fd_sc_hd.spice
.lib /home/marcus/.ciel/sky130A/libs.tech/ngspice/sky130.lib.spice tt
VPWR VPWR 0 1.8V
VNB VNB 0 0.0V
VPB VPB 0 1.8V
Iin 0 vin DC 0 AC 1uA
Xdut vin 0 VNB VPB VPWR vout sky130_fd_sc_hd__buf_1
